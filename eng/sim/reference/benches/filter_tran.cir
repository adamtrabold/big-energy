* BENCH filter_tran: self-oscillation onset. A small kick into the mixer bus, then free decay
* or growth. Placeholders: ADAPTER CUT R14 KICKW TMAX TSTOP WRFILE TEMP
.include ${ADAPTER}
.options temp=${TEMP} tnom=25 reltol=1e-5 abstol=1e-13 vntol=1e-7 method=gear maxord=2
vp vp 0 10
vn vn 0 -10
vcut cut 0 ${CUT}
vsrc src 0 pulse(0 10m 1m 1u 1u ${KICKW} 1e3)
rmix src ain 33k
rbus ain 0 5.5k
vamt amt 0 0
xf ain cut amt out vp vn dut_vcf r14=${R14}
.control
set wr_singlescale
set wr_vecnames
tran ${TMAX} ${TSTOP} 0 ${TMAX}
wrdata ${WRFILE} v(out)
quit
.endc
.end
