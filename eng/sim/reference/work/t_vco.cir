vco test
.include adapter.inc
.options temp=25 tnom=25 reltol=1e-4 abstol=1e-12 vntol=1e-6 method=gear maxord=2
vp vp 0 10
vn vn 0 -10
vkbd kbd 0 {4*0.0848}
vrng rng 0 {-5-0.298893*2}
vwid width 0 0
xv kbd rng width ramp saw tri rect vp vn dut_vco
vhold hold 0 -2
shold ramp hold hctl 0 swhold
vhctl hctl 0 pwl(0 1 1u 1 1.001u 0)
.model swhold sw(vt=0.5 vh=0 ron=1 roff=1e14)
.control
set wr_singlescale
set wr_vecnames
tran 20u 50m 0 20u
wrdata t_vco.dat v(ramp) v(saw) v(tri) v(rect)
quit
.endc
.end
