* BENCH vco_tran: one oscillator, free-running transient.
* Placeholders (filled by run_all.py): ADAPTER KBD RNG WIDTHNET TMAX TSTOP WRFILE TEMP DUTPARAMS
.include /home/claude/model-d/eng/sim/reference/work/golden/adapter.inc
.options temp=25 tnom=25 reltol=1e-4 abstol=1e-12 vntol=1e-6 method=gear maxord=2
vp vp 0 10
vn vn 0 -10
vkbd kbd 0 2.3744
vrng rng 0 -5.0
* rectangle width: the WAVEFORM switch's second pole (0 V, or the R032/R033/R034 divider)
r034 0 tapw 1.5k
r033 tapw width 1k
r032 width vn 7.5k
xv kbd rng width ramp saw tri rect vp vn dut_vco r11=149.991489 a8=0.135177
* start-up: hold the timing cap at -2 V for 1 us so the operating point converges
vhold hold 0 -2
shold ramp hold hctl 0 swhold
vhctl hctl 0 pwl(0 1 1u 1 1.001u 0)
.model swhold sw(vt=0.5 vh=0 ron=1 roff=1e14)
.control
set wr_singlescale
set wr_vecnames
tran 1.4205e-06 0.5 0 1.4205e-06
wrdata 1760Hz_narrow_m2v5.dat v(ramp) v(saw) v(tri) v(rect)
quit
.endc
.end
