* BENCH contour_tran: both contour generators, one gate.
* Placeholders: ADAPTER FA FD FS LA LD LS DECAYON TON TOFF TMAX TSTOP WRFILE TEMP
.include /home/claude/model-d/eng/sim/reference/work/example_perturbed/adapter.inc
.options temp=25 tnom=25 reltol=1e-4 abstol=1e-12 vntol=1e-7 method=gear maxord=2
vp15 vp15 0 15
vp10 vp10 0 10
vn10 vn10 0 -10
vgate gate 0 pwl(0 0 0.02 0 0.020001 1 3.0 1 3.000001 0)
xc gate fout lout vp15 vp10 vn10 dut_contour fa=1e+05 fd=1e+05 fs=0.5 la=1e+05 ld=1e+05 ls=0.5 decay_on=1
* loads: AMOUNT OF CONTOUR pot (5K) on the filter contour; the VCA input on the loudness
ramount fout 0 5k
rvca lout 0 2meg
.control
set wr_singlescale
set wr_vecnames
tran 0.0002 5.0 0 0.0002
wrdata mid_S5.dat v(fout) v(lout) v(gate)
quit
.endc
.end
